# Ansys Electronics Desktop project, version 2021.1
materials:
  vacuum: permittivity=1
  silicon: permittivity=11.9

design CavitySweep_hfss (HFSS, Eigenmode, model units mm)
variables:
  Lj = 0nH
  Cj = 0fF
geometry:
  prime_cpw_cplr_path = polyline((0, 0.000225, 0) (0, -0.000225, 0))
  prime_cpw_cplr = polyline((5.85e-06, 0.000225, 0) (-5.85e-06, 0.000225, 0))
  prime_cpw_cplr.sweep_along_path(prime_cpw_cplr_path)
  prime_cpw_sub_cplr_path = polyline((0, 0.000225, 0) (0, -0.000225, 0))
  prime_cpw_sub_cplr = polyline((1.095e-05, 0.000225, 0) (-1.095e-05, 0.000225, 0))
  prime_cpw_sub_cplr.sweep_along_path(prime_cpw_sub_cplr_path)
  second_cpw_cplr_path = polyline(z=0, xy: (-2.98e-05, 0.0001125) (-2.98e-05, -0.0001125) (-7.98e-05, -0.0001125))
  second_cpw_cplr_path.fillet(Vertices=second_cpw_cplr_path.vertex(2 of 3) Radius=2.5e-05 Setback=0mm)
  second_cpw_cplr = polyline((-2.395e-05, 0.0001125, 0) (-3.565e-05, 0.0001125, 0))
  second_cpw_cplr.sweep_along_path(second_cpw_cplr_path)
  second_cpw_sub_cplr_path = polyline(z=0, xy: (-2.98e-05, 0.0001125) (-2.98e-05, -0.0001125) (-7.98e-05, -0.0001125))
  second_cpw_sub_cplr_path.fillet(Vertices=second_cpw_sub_cplr_path.vertex(2 of 3) Radius=2.5e-05 Setback=0mm)
  second_cpw_sub_cplr = polyline((-1.885e-05, 0.0001125, 0) (-4.075e-05, 0.0001125, 0))
  second_cpw_sub_cplr.sweep_along_path(second_cpw_sub_cplr_path)
  trace_cpw_path = polyline(z=0, xy: (-7.98e-05, -0.0001125) (-0.0002298, -0.0001125) (-0.0002298, 0.00018606317) (-0.0003298, 0.00018606317) (-0.0003298, -0.00018606317) (-0.0004298, -0.00018606317) (-0.0004298, 0.00018606317) (-0.0005298, 0.00018606317) (-0.0005298, -0.00018606317) (-0.0006298, -0.00018606317) (-0.0006298, 0.00018606317) (-0.0007298, 0.00018606317) (-0.0007298, -0.00018606317) (-0.0008298, -0.00018606317) (-0.0008298, 0.00018606317) (-0.0009298, 0.00018606317) (-0.0009298, -0.00018606317) (-0.0010298, -0.00018606317) (-0.0010298, 0) (-0.0012058, 0))
  trace_cpw_path.fillet(Vertices=trace_cpw_path.vertex(2 of 20, 3 of 20, 4 of 20, 5 of 20, 6 of 20, 7 of 20, 8 of 20, 9 of 20, 10 of 20, 11 of 20, 12 of 20, 13 of 20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) Radius=4.99e-05 Setback=0mm)
  trace_cpw = polyline((-7.98e-05, -0.00011835, 0) (-7.98e-05, -0.00010665, 0))
  trace_cpw.sweep_along_path(trace_cpw_path)
  cut_cpw_path = polyline(z=0, xy: (-7.98e-05, -0.0001125) (-0.0002298, -0.0001125) (-0.0002298, 0.00018606317) (-0.0003298, 0.00018606317) (-0.0003298, -0.00018606317) (-0.0004298, -0.00018606317) (-0.0004298, 0.00018606317) (-0.0005298, 0.00018606317) (-0.0005298, -0.00018606317) (-0.0006298, -0.00018606317) (-0.0006298, 0.00018606317) (-0.0007298, 0.00018606317) (-0.0007298, -0.00018606317) (-0.0008298, -0.00018606317) (-0.0008298, 0.00018606317) (-0.0009298, 0.00018606317) (-0.0009298, -0.00018606317) (-0.0010298, -0.00018606317) (-0.0010298, 0) (-0.0012058, 0))
  cut_cpw_path.fillet(Vertices=cut_cpw_path.vertex(2 of 20, 3 of 20, 4 of 20, 5 of 20, 6 of 20, 7 of 20, 8 of 20, 9 of 20, 10 of 20, 11 of 20, 12 of 20, 13 of 20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) Radius=4.99e-05 Setback=0mm)
  cut_cpw = polyline((-7.98e-05, -0.00012345, 0) (-7.98e-05, -0.00010155, 0))
  cut_cpw.sweep_along_path(cut_cpw_path)
  readout_connector_arm_claw = polyline(z=0, xy: (-0.0012058, -5.85e-06) (-0.0012058, -6.92e-05) (-0.0013008, -6.92e-05) (-0.0013008, -5.42e-05) (-0.0012208, -5.42e-05) (-0.0012208, 5.42e-05) (-0.0013008, 5.42e-05) (-0.0013008, 6.92e-05) (-0.0012058, 6.92e-05) (-0.0012058, 5.85e-06) (-0.0012058, -5.85e-06), closed, covered)
  readout_connector_etcher_claw = polyline(z=0, xy: (-0.0012007, -7.43e-05) (-0.0013059, -7.43e-05) (-0.0013059, -4.91e-05) (-0.0012259, -4.91e-05) (-0.0012259, 4.91e-05) (-0.0013059, 4.91e-05) (-0.0013059, 7.43e-05) (-0.0012007, 7.43e-05) (-0.0012007, -7.43e-05), closed, covered)
  endcap_cplr_prime_start = rectangle(corner=(-1.287e-05, 0.000225, 0), x_size=2.574e-05, y_size=7.02e-06)
  endcap_cplr_prime_end = rectangle(corner=(-1.287e-05, -0.00023202, 0), x_size=2.574e-05, y_size=7.02e-06)
  endcap_cplr_prime_start_1 = rectangle(corner=(-1.287e-05, 0.000225, 0), x_size=2.574e-05, y_size=7.02e-06)
  endcap_cplr_prime_end_1 = rectangle(corner=(-1.287e-05, -0.00023202, 0), x_size=2.574e-05, y_size=7.02e-06)
  ground_main_plane = rectangle(corner=(-0.0015059, -0.000425, 0), x_size=0.0017059, y_size=0.00085)
  main [silicon] = box(corner=(-0.0015059, -0.000425, -0.00075), size=(0.0017059, 0.00085, 0.00075))
  sample_holder [vacuum] = box(corner=(-0.0015059, -0.000425, -0.00165), size=(0.0017059, 0.00085, 0.00254))
  ground_main_plane.subtract(prime_cpw_sub_cplr, readout_connector_etcher_claw, second_cpw_sub_cplr, endcap_cplr_prime_end, endcap_cplr_prime_start, cut_cpw)
  Port_cplr_prime_start = rectangle(corner=(-5.85e-06, 0.000225, 0), x_size=1.17e-05, y_size=7.02e-06)
  voltage_line_Port_cplr_prime_start = polyline((0, 0.000225, 0) (0, 0.00023202, 0))
  Port_cplr_prime_end = rectangle(corner=(-5.85e-06, -0.00023202, 0), x_size=1.17e-05, y_size=7.02e-06)
  voltage_line_Port_cplr_prime_end = polyline((0, -0.000225, 0) (0, -0.00023202, 0))
  ground_strip = rectangle(corner=(-7.98e-05, -0.000225, 0), x_size=7.98e-05, y_size=0.00045)
  ground_main_plane_1 = ground_main_plane.copy()
  ground_strip.intersect(ground_main_plane_1)
  ground_strip_1 = ground_strip.copy()
  ground_main_plane.subtract(ground_strip_1)
boundaries and excitations:
  RLCBoundary_cplr_prime_start: Lumped RLC Objects=Port_cplr_prime_start CurrentLine{middle of Port_cplr_prime_start.edge(y at corner) -> middle of Port_cplr_prime_start.edge(y opposite corner)} RLC_Type=Parallel Resistance=50ohm
  RLCBoundary_cplr_prime_end: Lumped RLC Objects=Port_cplr_prime_end CurrentLine{middle of Port_cplr_prime_end.edge(y at corner) -> middle of Port_cplr_prime_end.edge(y opposite corner)} RLC_Type=Parallel Resistance=50ohm
  PerfE: Perfect E Objects=[prime_cpw_cplr, second_cpw_cplr, trace_cpw, readout_connector_arm_claw, ground_main_plane]
  PerfE1: Perfect E Objects=ground_strip
mesh:
  port_mesh: LengthBased Objects=[Port_cplr_prime_start, Port_cplr_prime_end] MaxLength=4um
  mesh1: LengthBased Objects=[prime_cpw_cplr, second_cpw_cplr, trace_cpw, readout_connector_arm_claw] MaxLength=4um
  mesh_ground_strip: LengthBased Objects=ground_strip MaxLength=4um
setups:
  Setup: HfssEigen MinimumFrequency=1GHz NumModes=1 MaxDeltaFreq=0.05 ConvergeOnRealFreq=true MaximumPasses=30 MinimumPasses=2 MinimumConvergedPasses=1 PercentRefinement=30 BasisOrder=-1
source amplitudes:
  #-10:1: 1 0deg
